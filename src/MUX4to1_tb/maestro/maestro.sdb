ADE simulation setup
Run mode: Single Run, Sweeps and Corners
Tests:
  PhaseLockedLoop_MUX4to1_tb_1: PhaseLockedLoop/MUX4to1_tb/schematic, simulator spectre
