ADE simulation setup
Test ece5404_pll_MUX4to1_tb_1: ece5404_pll/MUX4to1_tb/schematic, simulator spectre
  Models: $GF_PDK_HOME/Spectre/models/design_wrapper.lib.scs[mainlib, FET_tt_pre, Res_nom, Cap_nom, MOSCap_nom, BEOL_nom, beta_nom]
  Temperature: 27
  Analysis tran: stop=800n errpreset=moderate
  Signals: /IN0, /IN1, /IN2, /IN3, /OUT, /S1, /S0
Test PhaseLockedLoop_MUX4to1_tb_1: PhaseLockedLoop/MUX4to1_tb/schematic, simulator spectre
  Models: $GF_PDK_HOME/Spectre/models/design_wrapper.lib.scs[mainlib, FET_tt_pre, Res_nom, Cap_nom, MOSCap_nom, BEOL_nom, beta_nom]
  Temperature: 27
  Analysis tran: stop=800n errpreset=moderate
  Signals: /IN0, /IN1, /IN2, /IN3, /OUT, /S1, /S0
