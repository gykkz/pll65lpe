ADE simulation setup
Test ece5404_pll_PFD_TB_1: ece5404_pll/PFD_TB/schematic, simulator spectre
  Models: $GF_PDK_HOME/Spectre/models/design_wrapper.lib.scs[mainlib, FET_tt_pre, Res_nom, Cap_nom, MOSCap_nom, BEOL_nom, beta_nom]
  Temperature: 27
  Files: DSPF \  
  Analysis tran: stop=200n errpreset=moderate
  Signals: /VCO, /VREF, /DOWN, /UP, /V7/MINUS (terminal), /V7/PLUS (terminal)
Test PhaseLockedLoop_PFD_tb_1: PhaseLockedLoop/PFD_tb/schematic, simulator spectre
  Models: $GF_PDK_HOME/Spectre/models/design_wrapper.lib.scs[mainlib, FET_tt_pre, Res_nom, Cap_nom, MOSCap_nom, BEOL_nom, beta_nom]
  Temperature: 27
  Analysis tran: stop=200n errpreset=moderate
  Signals: /VCO, /VREF, /DOWN, /UP
