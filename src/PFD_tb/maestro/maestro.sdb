ADE simulation setup
Run mode: Single Run, Sweeps and Corners
Tests:
  PhaseLockedLoop_PFD_tb_1: PhaseLockedLoop/PFD_tb/schematic, simulator spectre
