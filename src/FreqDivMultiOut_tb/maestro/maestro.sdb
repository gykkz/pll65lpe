ADE simulation setup
Run mode: Single Run, Sweeps and Corners
Tests:
  PhaseLockedLoop_FreqDivMultiOut_tb_1: PhaseLockedLoop/FreqDivMultiOut_tb/schematic, simulator spectre
    Variables: T = 5n
