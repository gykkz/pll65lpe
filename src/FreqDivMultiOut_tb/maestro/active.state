ADE simulation setup
Test ece5404_pll_freq_divider_tb_1: ece5404_pll/freq_divider_tb/schematic, simulator spectre
  Models: $GF_PDK_HOME/Spectre/models/design_wrapper.lib.scs[mainlib, FET_tt_pre, Res_nom, Cap_nom, MOSCap_nom, BEOL_nom, beta_nom]
  Variables: T = 5n
  Temperature: 27
  Analysis tran: stop=100n errpreset=moderate
  Signals: /Fin, /FD_NODIV, /DIV2, /DIV4, /DIV8
Test PhaseLockedLoop_FreqDivMultiOut_tb_1: PhaseLockedLoop/FreqDivMultiOut_tb/schematic, simulator spectre
  Models: $GF_PDK_HOME/Spectre/models/design_wrapper.lib.scs[mainlib, FET_tt_pre, Res_nom, Cap_nom, MOSCap_nom, BEOL_nom, beta_nom]
  Variables: T = 5n
  Temperature: 27
  Analysis tran: stop=100n errpreset=moderate
  Signals: /Fin, /FD_NODIV, /DIV2, /DIV4, /DIV8
