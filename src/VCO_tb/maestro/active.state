ADE simulation setup
Test ece5404_pll_VCO_tb_1: ece5404_pll/VCO_tb/schematic, simulator spectre
  Models: $GF_PDK_HOME/Spectre/models/design_wrapper.lib.scs[mainlib, FET_tt_pre, Res_nom, Cap_nom, MOSCap_nom, BEOL_nom, beta_nom]
  Variables: Vvco = 0.7
  Temperature: 27
  Files: DSPF \  
  Initial conditions: /I6/Vfb = 0
  Analysis tran: stop=400n errpreset=moderate
  Output duty_cycle = dutyCycle(clip(VT("/OUT") 0.0 2e-07) ?mode "user" ?threshold 0.599918 ?xName "time" ?outputType "plot")
  Output average(dutyCycle(clip(VT("/OUT") 0.0 2e-07) ?mode "user" ?threshold 0.599918 ?xName "time" ?outputType "plot"))
  Output freq = average(freq(clip(VT("/OUT") 0.0 5e-08) "rising" ?xName "time" ?mode "user" ?threshold 0.599866))
  Signals: /Vctrl, /OUT
Test PhaseLockedLoop_VCO_tb_1: PhaseLockedLoop/VCO_tb/schematic, simulator spectre
  Models: $GF_PDK_HOME/Spectre/models/design_wrapper.lib.scs[mainlib, FET_tt_pre, Res_nom, Cap_nom, MOSCap_nom, BEOL_nom, beta_nom]
  Variables: Vvco = 0.7
  Temperature: 27
  Initial conditions: /I6/Vfb = 0
  Analysis tran: stop=400n errpreset=moderate
  Output duty_cycle = dutyCycle(clip(VT("/OUT") 0.0 2e-07) ?mode "user" ?threshold 0.599918 ?xName "time" ?outputType "plot")
  Output average(dutyCycle(clip(VT("/OUT") 0.0 2e-07) ?mode "user" ?threshold 0.599918 ?xName "time" ?outputType "plot"))
  Output freq = average(freq(clip(VT("/OUT") 0.0 5e-08) "rising" ?xName "time" ?mode "user" ?threshold 0.599866))
  Signals: /Vctrl, /OUT
