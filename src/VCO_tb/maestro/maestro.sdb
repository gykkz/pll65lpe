ADE simulation setup
Run mode: Single Run, Sweeps and Corners
Tests:
  PhaseLockedLoop_VCO_tb_1: PhaseLockedLoop/VCO_tb/schematic, simulator spectre
    Variables: Vvco = {From/To}Linear:.6:0.05:1.2{From/To}
