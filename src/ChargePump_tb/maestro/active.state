ADE simulation setup
Test PhaseLockedLoop_ChargePump_tb_1: PhaseLockedLoop/ChargePump_tb/schematic, simulator spectre
  Models: $GF_PDK_HOME/Spectre/models/design_wrapper.lib.scs[mainlib, FET_tt_pre, Res_nom, Cap_nom, MOSCap_nom, BEOL_nom, beta_nom]
  Temperature: 27
  Analysis tran: stop=150n errpreset=moderate
  Signals: /UP, /DN, /CPOUT
Run mode: Single Run, Sweeps and Corners
