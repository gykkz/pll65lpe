ADE simulation setup
Run mode: Single Run, Sweeps and Corners
Tests:
  PhaseLockedLoop_ChargePump_tb_1: PhaseLockedLoop/ChargePump_tb/schematic, simulator spectre
