ADE simulation setup
Test ece5404_pll_PLL_tb_1: ece5404_pll/PLL_tb/schematic, simulator spectre
  Models: $GF_PDK_HOME/Spectre/models/design_wrapper.lib.scs[mainlib, FET_tt_pre, Res_nom, Cap_nom, MOSCap_nom, BEOL_nom, beta_nom]
  Variables: VDD_p = 1.2
  Temperature: 27
  Files: DSPF \  
  Initial conditions: /I0/I9/Vfb = 0
  Analysis tran: stop=20u errpreset=moderate
  Signals: /IN, /S1, /S0, /OUT
Test PhaseLockedLoop_PLL_tb_1: PhaseLockedLoop/PLL_tb/schematic, simulator spectre
  Models: $GF_PDK_HOME/Spectre/models/design_wrapper.lib.scs[mainlib, FET_tt_pre, Res_nom, Cap_nom, MOSCap_nom, BEOL_nom, beta_nom]
  Variables: VDD_p = 1.2
  Temperature: 27
  Initial conditions: /I0/I9/Vfb = 0
  Analysis tran: stop=20u errpreset=moderate
  Signals: /IN, /S1, /S0, /OUT
