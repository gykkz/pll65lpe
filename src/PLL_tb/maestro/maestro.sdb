ADE simulation setup
Run mode: Single Run, Sweeps and Corners
Tests:
  PhaseLockedLoop_PLL_tb_1: PhaseLockedLoop/PLL_tb/schematic, simulator spectre
    Variables: VDD_p = 1.2
Corners (nominal off):
  model folders: $GF_PDK_HOME/Spectre/models
  every corner: $GF_PDK_HOME/Spectre/models/design_wrapper.lib.scs[mainlib, Res_nom, Cap_nom, MOSCap_nom, BEOL_nom, beta_nom]
  FF_1P32V_125C: temperature=125; VDD_p=1.32; design_wrapper.lib.scs[FET_fff_pre]
  SS_1P08_M40C: temperature=-40; VDD_p=1.08; design_wrapper.lib.scs[FET_ssf_pre]
  TT_1P2_25C: temperature=25; VDD_p=1.2; design_wrapper.lib.scs[FET_tt_pre]
