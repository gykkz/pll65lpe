ADE simulation setup
Test ece5404_pll_TSPC_DFF_sal_TB_1: ece5404_pll/TSPC_DFF_sal_TB/schematic, simulator spectre
  Models: $GF_PDK_HOME/Spectre/models/design_wrapper.lib.scs[mainlib, FET_tt_pre, Res_nom, Cap_nom, MOSCap_nom, BEOL_nom, beta_nom]
  Temperature: 27
  Analysis tran: stop=200n errpreset=moderate
  Signals: /D, /CLK, /Q, /Qbar
Test PhaseLockedLoop_TSPC_DFF_sal_tb_1: PhaseLockedLoop/TSPC_DFF_sal_tb/schematic, simulator spectre
  Models: $GF_PDK_HOME/Spectre/models/design_wrapper.lib.scs[mainlib, FET_tt_pre, Res_nom, Cap_nom, MOSCap_nom, BEOL_nom, beta_nom]
  Temperature: 27
  Analysis tran: stop=200n errpreset=moderate
  Signals: /D, /CLK, /Q, /Qbar
