ADE simulation setup
Run mode: Single Run, Sweeps and Corners
Tests:
  PhaseLockedLoop_TSPC_DFF_sal_tb_1: PhaseLockedLoop/TSPC_DFF_sal_tb/schematic, simulator spectre
